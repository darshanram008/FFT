$ Spice netlist generated by v2lvs
$ v2024.3_25.13    Thu Aug 1 18:56:55 PDT 2024
.INCLUDE "/courses/ee6350/pdk2025/tcbn65gplus/TSMCHOME/digital/Back_End/spice/tcbn65gplus_200a/tcbn65gplus_200a.spi"
.INCLUDE "/user/stud/fall25/dr3412/EECS6321_Adv_dig/fft/innovus/fft_controller/fft_controller.cdl"
.INCLUDE "/user/stud/fall25/dr3412/EECS6321_Adv_dig/fft/innovus/fft_twiddle_sram/fft_twiddle_sram.cdl"
.INCLUDE "/user/stud/fall25/dr3412/EECS6321_Adv_dig/fft/innovus/fft_data_sram/fft_data_sram.cdl"
.INCLUDE "/user/stud/fall25/dr3412/EECS6321_Adv_dig/fft/innovus/fft_core/fft_core.cdl"
.INCLUDE "/user/stud/fall25/dr3412/EECS6321_Adv_dig/fft/innovus/fft_address_gen/fft_address_gen.cdl"
.INCLUDE "/user/stud/fall25/dr3412/EECS6321_Adv_dig/fft/innovus/sram_wrapper/sram_wrapper.cdl"
*.BUSDELIMITER [

.SUBCKT fft_top VDD VSS clk rstn start busy done tb_data_cen tb_data_wen
+ tb_data_addr[9] tb_data_addr[8] tb_data_addr[7] tb_data_addr[6]
+ tb_data_addr[5] tb_data_addr[4] tb_data_addr[3] tb_data_addr[2]
+ tb_data_addr[1] tb_data_addr[0] tb_data_din[31] tb_data_din[30]
+ tb_data_din[29] tb_data_din[28] tb_data_din[27] tb_data_din[26]
+ tb_data_din[25] tb_data_din[24] tb_data_din[23] tb_data_din[22]
+ tb_data_din[21] tb_data_din[20] tb_data_din[19] tb_data_din[18]
+ tb_data_din[17] tb_data_din[16] tb_data_din[15] tb_data_din[14]
+ tb_data_din[13] tb_data_din[12] tb_data_din[11] tb_data_din[10]
+ tb_data_din[9] tb_data_din[8] tb_data_din[7] tb_data_din[6] tb_data_din[5]
+ tb_data_din[4] tb_data_din[3] tb_data_din[2] tb_data_din[1] tb_data_din[0]
+ tb_data_dout[31] tb_data_dout[30] tb_data_dout[29] tb_data_dout[28]
+ tb_data_dout[27] tb_data_dout[26] tb_data_dout[25] tb_data_dout[24]
+ tb_data_dout[23] tb_data_dout[22] tb_data_dout[21] tb_data_dout[20]
+ tb_data_dout[19] tb_data_dout[18] tb_data_dout[17] tb_data_dout[16]
+ tb_data_dout[15] tb_data_dout[14] tb_data_dout[13] tb_data_dout[12]
+ tb_data_dout[11] tb_data_dout[10] tb_data_dout[9] tb_data_dout[8]
+ tb_data_dout[7] tb_data_dout[6] tb_data_dout[5] tb_data_dout[4]
+ tb_data_dout[3] tb_data_dout[2] tb_data_dout[1] tb_data_dout[0] tb_tw_cen
+ tb_tw_wen tb_tw_addr[8] tb_tw_addr[7] tb_tw_addr[6] tb_tw_addr[5]
+ tb_tw_addr[4] tb_tw_addr[3] tb_tw_addr[2] tb_tw_addr[1] tb_tw_addr[0]
+ tb_tw_din[31] tb_tw_din[30] tb_tw_din[29] tb_tw_din[28] tb_tw_din[27]
+ tb_tw_din[26] tb_tw_din[25] tb_tw_din[24] tb_tw_din[23] tb_tw_din[22]
+ tb_tw_din[21] tb_tw_din[20] tb_tw_din[19] tb_tw_din[18] tb_tw_din[17]
+ tb_tw_din[16] tb_tw_din[15] tb_tw_din[14] tb_tw_din[13] tb_tw_din[12]
+ tb_tw_din[11] tb_tw_din[10] tb_tw_din[9] tb_tw_din[8] tb_tw_din[7]
+ tb_tw_din[6] tb_tw_din[5] tb_tw_din[4] tb_tw_din[3] tb_tw_din[2] tb_tw_din[1]
+ tb_tw_din[0] tb_tw_dout[31] tb_tw_dout[30] tb_tw_dout[29] tb_tw_dout[28]
+ tb_tw_dout[27] tb_tw_dout[26] tb_tw_dout[25] tb_tw_dout[24] tb_tw_dout[23]
+ tb_tw_dout[22] tb_tw_dout[21] tb_tw_dout[20] tb_tw_dout[19] tb_tw_dout[18]
+ tb_tw_dout[17] tb_tw_dout[16] tb_tw_dout[15] tb_tw_dout[14] tb_tw_dout[13]
+ tb_tw_dout[12] tb_tw_dout[11] tb_tw_dout[10] tb_tw_dout[9] tb_tw_dout[8]
+ tb_tw_dout[7] tb_tw_dout[6] tb_tw_dout[5] tb_tw_dout[4] tb_tw_dout[3]
+ tb_tw_dout[2] tb_tw_dout[1] tb_tw_dout[0] tb_linear_addr[9] tb_linear_addr[8]
+ tb_linear_addr[7] tb_linear_addr[6] tb_linear_addr[5] tb_linear_addr[4]
+ tb_linear_addr[3] tb_linear_addr[2] tb_linear_addr[1] tb_linear_addr[0]
+ tb_bitrev_addr[9] tb_bitrev_addr[8] tb_bitrev_addr[7] tb_bitrev_addr[6]
+ tb_bitrev_addr[5] tb_bitrev_addr[4] tb_bitrev_addr[3] tb_bitrev_addr[2]
+ tb_bitrev_addr[1] tb_bitrev_addr[0]
*.CONNECT tb_data_dout[0] data_dout[0]
*.CONNECT tb_data_dout[1] data_dout[1]
*.CONNECT tb_data_dout[2] data_dout[2]
*.CONNECT tb_data_dout[3] data_dout[3]
*.CONNECT tb_data_dout[4] data_dout[4]
*.CONNECT tb_data_dout[5] data_dout[5]
*.CONNECT tb_data_dout[6] data_dout[6]
*.CONNECT tb_data_dout[7] data_dout[7]
*.CONNECT tb_data_dout[8] data_dout[8]
*.CONNECT tb_data_dout[9] data_dout[9]
*.CONNECT tb_data_dout[10] data_dout[10]
*.CONNECT tb_data_dout[11] data_dout[11]
*.CONNECT tb_data_dout[12] data_dout[12]
*.CONNECT tb_data_dout[13] data_dout[13]
*.CONNECT tb_data_dout[14] data_dout[14]
*.CONNECT tb_data_dout[15] data_dout[15]
*.CONNECT tb_data_dout[16] data_dout[16]
*.CONNECT tb_data_dout[17] data_dout[17]
*.CONNECT tb_data_dout[18] data_dout[18]
*.CONNECT tb_data_dout[19] data_dout[19]
*.CONNECT tb_data_dout[20] data_dout[20]
*.CONNECT tb_data_dout[21] data_dout[21]
*.CONNECT tb_data_dout[22] data_dout[22]
*.CONNECT tb_data_dout[23] data_dout[23]
*.CONNECT tb_data_dout[24] data_dout[24]
*.CONNECT tb_data_dout[25] data_dout[25]
*.CONNECT tb_data_dout[26] data_dout[26]
*.CONNECT tb_data_dout[27] data_dout[27]
*.CONNECT tb_data_dout[28] data_dout[28]
*.CONNECT tb_data_dout[29] data_dout[29]
*.CONNECT tb_data_dout[30] data_dout[30]
*.CONNECT tb_data_dout[31] data_dout[31]
*.CONNECT tb_tw_dout[0] tw_dout[0]
*.CONNECT tb_tw_dout[1] tw_dout[1]
*.CONNECT tb_tw_dout[2] tw_dout[2]
*.CONNECT tb_tw_dout[3] tw_dout[3]
*.CONNECT tb_tw_dout[4] tw_dout[4]
*.CONNECT tb_tw_dout[5] tw_dout[5]
*.CONNECT tb_tw_dout[6] tw_dout[6]
*.CONNECT tb_tw_dout[7] tw_dout[7]
*.CONNECT tb_tw_dout[8] tw_dout[8]
*.CONNECT tb_tw_dout[9] tw_dout[9]
*.CONNECT tb_tw_dout[10] tw_dout[10]
*.CONNECT tb_tw_dout[11] tw_dout[11]
*.CONNECT tb_tw_dout[12] tw_dout[12]
*.CONNECT tb_tw_dout[13] tw_dout[13]
*.CONNECT tb_tw_dout[14] tw_dout[14]
*.CONNECT tb_tw_dout[15] tw_dout[15]
*.CONNECT tb_tw_dout[16] tw_dout[16]
*.CONNECT tb_tw_dout[17] tw_dout[17]
*.CONNECT tb_tw_dout[18] tw_dout[18]
*.CONNECT tb_tw_dout[19] tw_dout[19]
*.CONNECT tb_tw_dout[20] tw_dout[20]
*.CONNECT tb_tw_dout[21] tw_dout[21]
*.CONNECT tb_tw_dout[22] tw_dout[22]
*.CONNECT tb_tw_dout[23] tw_dout[23]
*.CONNECT tb_tw_dout[24] tw_dout[24]
*.CONNECT tb_tw_dout[25] tw_dout[25]
*.CONNECT tb_tw_dout[26] tw_dout[26]
*.CONNECT tb_tw_dout[27] tw_dout[27]
*.CONNECT tb_tw_dout[28] tw_dout[28]
*.CONNECT tb_tw_dout[29] tw_dout[29]
*.CONNECT tb_tw_dout[30] tw_dout[30]
*.CONNECT tb_tw_dout[31] tw_dout[31]
Xu_addr stage[3] stage[2] stage[1] stage[0] group[8] group[7] group[6] group[5]
+ group[4] group[3] group[2] group[1] group[0] bfly[8] bfly[7] bfly[6] bfly[5]
+ bfly[4] bfly[3] bfly[2] bfly[1] bfly[0] tb_linear_addr[9] tb_linear_addr[8]
+ tb_linear_addr[7] tb_linear_addr[6] tb_linear_addr[5] tb_linear_addr[4]
+ tb_linear_addr[3] tb_linear_addr[2] tb_linear_addr[1] tb_linear_addr[0]
+ x0_addr[9] x0_addr[8] x0_addr[7] x0_addr[6] x0_addr[5] x0_addr[4] x0_addr[3]
+ x0_addr[2] x0_addr[1] x0_addr[0] x1_addr[9] x1_addr[8] x1_addr[7] x1_addr[6]
+ x1_addr[5] x1_addr[4] x1_addr[3] x1_addr[2] x1_addr[1] x1_addr[0] w_addr[8]
+ w_addr[7] w_addr[6] w_addr[5] w_addr[4] w_addr[3] w_addr[2] w_addr[1]
+ w_addr[0] tb_bitrev_addr[9] tb_bitrev_addr[8] tb_bitrev_addr[7]
+ tb_bitrev_addr[6] tb_bitrev_addr[5] tb_bitrev_addr[4] tb_bitrev_addr[3]
+ tb_bitrev_addr[2] tb_bitrev_addr[1] tb_bitrev_addr[0] VDD VSS fft_address_gen
Xu_core clk rstn core_start core_x0[31] core_x0[30] core_x0[29] core_x0[28]
+ core_x0[27] core_x0[26] core_x0[25] core_x0[24] core_x0[23] core_x0[22]
+ core_x0[21] core_x0[20] core_x0[19] core_x0[18] core_x0[17] core_x0[16]
+ core_x0[15] core_x0[14] core_x0[13] core_x0[12] core_x0[11] core_x0[10]
+ core_x0[9] core_x0[8] core_x0[7] core_x0[6] core_x0[5] core_x0[4] core_x0[3]
+ core_x0[2] core_x0[1] core_x0[0] core_x1[31] core_x1[30] core_x1[29]
+ core_x1[28] core_x1[27] core_x1[26] core_x1[25] core_x1[24] core_x1[23]
+ core_x1[22] core_x1[21] core_x1[20] core_x1[19] core_x1[18] core_x1[17]
+ core_x1[16] core_x1[15] core_x1[14] core_x1[13] core_x1[12] core_x1[11]
+ core_x1[10] core_x1[9] core_x1[8] core_x1[7] core_x1[6] core_x1[5] core_x1[4]
+ core_x1[3] core_x1[2] core_x1[1] core_x1[0] core_w[31] core_w[30] core_w[29]
+ core_w[28] core_w[27] core_w[26] core_w[25] core_w[24] core_w[23] core_w[22]
+ core_w[21] core_w[20] core_w[19] core_w[18] core_w[17] core_w[16] core_w[15]
+ core_w[14] core_w[13] core_w[12] core_w[11] core_w[10] core_w[9] core_w[8]
+ core_w[7] core_w[6] core_w[5] core_w[4] core_w[3] core_w[2] core_w[1]
+ core_w[0] core_x0_out[31] core_x0_out[30] core_x0_out[29] core_x0_out[28]
+ core_x0_out[27] core_x0_out[26] core_x0_out[25] core_x0_out[24]
+ core_x0_out[23] core_x0_out[22] core_x0_out[21] core_x0_out[20]
+ core_x0_out[19] core_x0_out[18] core_x0_out[17] core_x0_out[16]
+ core_x0_out[15] core_x0_out[14] core_x0_out[13] core_x0_out[12]
+ core_x0_out[11] core_x0_out[10] core_x0_out[9] core_x0_out[8] core_x0_out[7]
+ core_x0_out[6] core_x0_out[5] core_x0_out[4] core_x0_out[3] core_x0_out[2]
+ core_x0_out[1] core_x0_out[0] core_x1_out[31] core_x1_out[30] core_x1_out[29]
+ core_x1_out[28] core_x1_out[27] core_x1_out[26] core_x1_out[25]
+ core_x1_out[24] core_x1_out[23] core_x1_out[22] core_x1_out[21]
+ core_x1_out[20] core_x1_out[19] core_x1_out[18] core_x1_out[17]
+ core_x1_out[16] core_x1_out[15] core_x1_out[14] core_x1_out[13]
+ core_x1_out[12] core_x1_out[11] core_x1_out[10] core_x1_out[9] core_x1_out[8]
+ core_x1_out[7] core_x1_out[6] core_x1_out[5] core_x1_out[4] core_x1_out[3]
+ core_x1_out[2] core_x1_out[1] core_x1_out[0] core_done VDD VSS fft_core
Xu_ctrl clk rstn start data_dout[31] data_dout[30] data_dout[29] data_dout[28]
+ data_dout[27] data_dout[26] data_dout[25] data_dout[24] data_dout[23]
+ data_dout[22] data_dout[21] data_dout[20] data_dout[19] data_dout[18]
+ data_dout[17] data_dout[16] data_dout[15] data_dout[14] data_dout[13]
+ data_dout[12] data_dout[11] data_dout[10] data_dout[9] data_dout[8]
+ data_dout[7] data_dout[6] data_dout[5] data_dout[4] data_dout[3] data_dout[2]
+ data_dout[1] data_dout[0] tw_dout[31] tw_dout[30] tw_dout[29] tw_dout[28]
+ tw_dout[27] tw_dout[26] tw_dout[25] tw_dout[24] tw_dout[23] tw_dout[22]
+ tw_dout[21] tw_dout[20] tw_dout[19] tw_dout[18] tw_dout[17] tw_dout[16]
+ tw_dout[15] tw_dout[14] tw_dout[13] tw_dout[12] tw_dout[11] tw_dout[10]
+ tw_dout[9] tw_dout[8] tw_dout[7] tw_dout[6] tw_dout[5] tw_dout[4] tw_dout[3]
+ tw_dout[2] tw_dout[1] tw_dout[0] core_done core_start core_x0[31] core_x0[30]
+ core_x0[29] core_x0[28] core_x0[27] core_x0[26] core_x0[25] core_x0[24]
+ core_x0[23] core_x0[22] core_x0[21] core_x0[20] core_x0[19] core_x0[18]
+ core_x0[17] core_x0[16] core_x0[15] core_x0[14] core_x0[13] core_x0[12]
+ core_x0[11] core_x0[10] core_x0[9] core_x0[8] core_x0[7] core_x0[6]
+ core_x0[5] core_x0[4] core_x0[3] core_x0[2] core_x0[1] core_x0[0] core_x1[31]
+ core_x1[30] core_x1[29] core_x1[28] core_x1[27] core_x1[26] core_x1[25]
+ core_x1[24] core_x1[23] core_x1[22] core_x1[21] core_x1[20] core_x1[19]
+ core_x1[18] core_x1[17] core_x1[16] core_x1[15] core_x1[14] core_x1[13]
+ core_x1[12] core_x1[11] core_x1[10] core_x1[9] core_x1[8] core_x1[7]
+ core_x1[6] core_x1[5] core_x1[4] core_x1[3] core_x1[2] core_x1[1] core_x1[0]
+ core_w[31] core_w[30] core_w[29] core_w[28] core_w[27] core_w[26] core_w[25]
+ core_w[24] core_w[23] core_w[22] core_w[21] core_w[20] core_w[19] core_w[18]
+ core_w[17] core_w[16] core_w[15] core_w[14] core_w[13] core_w[12] core_w[11]
+ core_w[10] core_w[9] core_w[8] core_w[7] core_w[6] core_w[5] core_w[4]
+ core_w[3] core_w[2] core_w[1] core_w[0] core_x0_out[31] core_x0_out[30]
+ core_x0_out[29] core_x0_out[28] core_x0_out[27] core_x0_out[26]
+ core_x0_out[25] core_x0_out[24] core_x0_out[23] core_x0_out[22]
+ core_x0_out[21] core_x0_out[20] core_x0_out[19] core_x0_out[18]
+ core_x0_out[17] core_x0_out[16] core_x0_out[15] core_x0_out[14]
+ core_x0_out[13] core_x0_out[12] core_x0_out[11] core_x0_out[10]
+ core_x0_out[9] core_x0_out[8] core_x0_out[7] core_x0_out[6] core_x0_out[5]
+ core_x0_out[4] core_x0_out[3] core_x0_out[2] core_x0_out[1] core_x0_out[0]
+ core_x1_out[31] core_x1_out[30] core_x1_out[29] core_x1_out[28]
+ core_x1_out[27] core_x1_out[26] core_x1_out[25] core_x1_out[24]
+ core_x1_out[23] core_x1_out[22] core_x1_out[21] core_x1_out[20]
+ core_x1_out[19] core_x1_out[18] core_x1_out[17] core_x1_out[16]
+ core_x1_out[15] core_x1_out[14] core_x1_out[13] core_x1_out[12]
+ core_x1_out[11] core_x1_out[10] core_x1_out[9] core_x1_out[8] core_x1_out[7]
+ core_x1_out[6] core_x1_out[5] core_x1_out[4] core_x1_out[3] core_x1_out[2]
+ core_x1_out[1] core_x1_out[0] stage[3] stage[2] stage[1] stage[0] group[8]
+ group[7] group[6] group[5] group[4] group[3] group[2] group[1] group[0]
+ bfly[8] bfly[7] bfly[6] bfly[5] bfly[4] bfly[3] bfly[2] bfly[1] bfly[0]
+ x0_addr[9] x0_addr[8] x0_addr[7] x0_addr[6] x0_addr[5] x0_addr[4] x0_addr[3]
+ x0_addr[2] x0_addr[1] x0_addr[0] x1_addr[9] x1_addr[8] x1_addr[7] x1_addr[6]
+ x1_addr[5] x1_addr[4] x1_addr[3] x1_addr[2] x1_addr[1] x1_addr[0] w_addr[8]
+ w_addr[7] w_addr[6] w_addr[5] w_addr[4] w_addr[3] w_addr[2] w_addr[1]
+ w_addr[0] core_data_cen core_data_wen core_data_addr[9] core_data_addr[8]
+ core_data_addr[7] core_data_addr[6] core_data_addr[5] core_data_addr[4]
+ core_data_addr[3] core_data_addr[2] core_data_addr[1] core_data_addr[0]
+ core_data_din[31] core_data_din[30] core_data_din[29] core_data_din[28]
+ core_data_din[27] core_data_din[26] core_data_din[25] core_data_din[24]
+ core_data_din[23] core_data_din[22] core_data_din[21] core_data_din[20]
+ core_data_din[19] core_data_din[18] core_data_din[17] core_data_din[16]
+ core_data_din[15] core_data_din[14] core_data_din[13] core_data_din[12]
+ core_data_din[11] core_data_din[10] core_data_din[9] core_data_din[8]
+ core_data_din[7] core_data_din[6] core_data_din[5] core_data_din[4]
+ core_data_din[3] core_data_din[2] core_data_din[1] core_data_din[0]
+ core_tw_cen core_tw_addr[8] core_tw_addr[7] core_tw_addr[6] core_tw_addr[5]
+ core_tw_addr[4] core_tw_addr[3] core_tw_addr[2] core_tw_addr[1]
+ core_tw_addr[0] sram_tb_sel busy done VDD VSS fft_controller
Xu_data_sram clk sram_tb_sel tb_data_cen tb_data_wen tb_data_addr[9]
+ tb_data_addr[8] tb_data_addr[7] tb_data_addr[6] tb_data_addr[5]
+ tb_data_addr[4] tb_data_addr[3] tb_data_addr[2] tb_data_addr[1]
+ tb_data_addr[0] tb_data_din[31] tb_data_din[30] tb_data_din[29]
+ tb_data_din[28] tb_data_din[27] tb_data_din[26] tb_data_din[25]
+ tb_data_din[24] tb_data_din[23] tb_data_din[22] tb_data_din[21]
+ tb_data_din[20] tb_data_din[19] tb_data_din[18] tb_data_din[17]
+ tb_data_din[16] tb_data_din[15] tb_data_din[14] tb_data_din[13]
+ tb_data_din[12] tb_data_din[11] tb_data_din[10] tb_data_din[9] tb_data_din[8]
+ tb_data_din[7] tb_data_din[6] tb_data_din[5] tb_data_din[4] tb_data_din[3]
+ tb_data_din[2] tb_data_din[1] tb_data_din[0] core_data_cen core_data_wen
+ core_data_addr[9] core_data_addr[8] core_data_addr[7] core_data_addr[6]
+ core_data_addr[5] core_data_addr[4] core_data_addr[3] core_data_addr[2]
+ core_data_addr[1] core_data_addr[0] core_data_din[31] core_data_din[30]
+ core_data_din[29] core_data_din[28] core_data_din[27] core_data_din[26]
+ core_data_din[25] core_data_din[24] core_data_din[23] core_data_din[22]
+ core_data_din[21] core_data_din[20] core_data_din[19] core_data_din[18]
+ core_data_din[17] core_data_din[16] core_data_din[15] core_data_din[14]
+ core_data_din[13] core_data_din[12] core_data_din[11] core_data_din[10]
+ core_data_din[9] core_data_din[8] core_data_din[7] core_data_din[6]
+ core_data_din[5] core_data_din[4] core_data_din[3] core_data_din[2]
+ core_data_din[1] core_data_din[0] data_dout[31] data_dout[30] data_dout[29]
+ data_dout[28] data_dout[27] data_dout[26] data_dout[25] data_dout[24]
+ data_dout[23] data_dout[22] data_dout[21] data_dout[20] data_dout[19]
+ data_dout[18] data_dout[17] data_dout[16] data_dout[15] data_dout[14]
+ data_dout[13] data_dout[12] data_dout[11] data_dout[10] data_dout[9]
+ data_dout[8] data_dout[7] data_dout[6] data_dout[5] data_dout[4] data_dout[3]
+ data_dout[2] data_dout[1] data_dout[0] VDD VSS fft_data_sram
Xu_tw_sram clk sram_tb_sel tb_tw_cen tb_tw_wen tb_tw_addr[8] tb_tw_addr[7]
+ tb_tw_addr[6] tb_tw_addr[5] tb_tw_addr[4] tb_tw_addr[3] tb_tw_addr[2]
+ tb_tw_addr[1] tb_tw_addr[0] tb_tw_din[31] tb_tw_din[30] tb_tw_din[29]
+ tb_tw_din[28] tb_tw_din[27] tb_tw_din[26] tb_tw_din[25] tb_tw_din[24]
+ tb_tw_din[23] tb_tw_din[22] tb_tw_din[21] tb_tw_din[20] tb_tw_din[19]
+ tb_tw_din[18] tb_tw_din[17] tb_tw_din[16] tb_tw_din[15] tb_tw_din[14]
+ tb_tw_din[13] tb_tw_din[12] tb_tw_din[11] tb_tw_din[10] tb_tw_din[9]
+ tb_tw_din[8] tb_tw_din[7] tb_tw_din[6] tb_tw_din[5] tb_tw_din[4] tb_tw_din[3]
+ tb_tw_din[2] tb_tw_din[1] tb_tw_din[0] core_tw_cen core_tw_addr[8]
+ core_tw_addr[7] core_tw_addr[6] core_tw_addr[5] core_tw_addr[4]
+ core_tw_addr[3] core_tw_addr[2] core_tw_addr[1] core_tw_addr[0] tw_dout[31]
+ tw_dout[30] tw_dout[29] tw_dout[28] tw_dout[27] tw_dout[26] tw_dout[25]
+ tw_dout[24] tw_dout[23] tw_dout[22] tw_dout[21] tw_dout[20] tw_dout[19]
+ tw_dout[18] tw_dout[17] tw_dout[16] tw_dout[15] tw_dout[14] tw_dout[13]
+ tw_dout[12] tw_dout[11] tw_dout[10] tw_dout[9] tw_dout[8] tw_dout[7]
+ tw_dout[6] tw_dout[5] tw_dout[4] tw_dout[3] tw_dout[2] tw_dout[1] tw_dout[0]
+ VDD VSS fft_twiddle_sram
.ENDS
